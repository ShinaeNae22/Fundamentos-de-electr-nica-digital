* C:\Program Files\OrCAD_Demo\PSpice\UserLib\PEC1\PEC1.sch

* Schematics Version 9.1 - Web Update 1
* Tue Nov 13 17:18:20 2018

** Analysis setup **
.tran 2ms 5ms

* From [PSPICE NETLIST] section of pspiceev.ini:
.lib "nom.lib"

.INC "PEC1.net"
.INC "PEC1.als"

.probe

.END
